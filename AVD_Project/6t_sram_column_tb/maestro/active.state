ADE simulation setup
Test AVD_Project_6t_sram_tb_1: AVD_Project/6t_sram_column_tb/schematic, simulator spectre
  Models: /package/eda/cadence/gpdk045/gpdk045_v_6_0/gpdk045/../models/spectre/gpdk045.scs[tt]
  Temperature: 27
  Stimulus Vdd: voltage dc dc=1 srcType=dc
  Stimulus Vss: voltage dc dc=0 srcType=dc
  Stimulus WL<63>: voltage dc dc=0 srcType=dc
  Stimulus WL<62>: voltage dc dc=0 srcType=dc
  Stimulus WL<61>: voltage dc dc=0 srcType=dc
  Stimulus WL<60>: voltage dc dc=0 srcType=dc
  Stimulus WL<59>: voltage dc dc=0 srcType=dc
  Stimulus WL<58>: voltage dc dc=0 srcType=dc
  Stimulus WL<57>: voltage dc dc=0 srcType=dc
  Stimulus WL<56>: voltage dc dc=0 srcType=dc
  Stimulus WL<55>: voltage dc dc=0 srcType=dc
  Stimulus WL<54>: voltage dc dc=0 srcType=dc
  Stimulus WL<53>: voltage dc dc=0 srcType=dc
  Stimulus WL<52>: voltage dc dc=0 srcType=dc
  Stimulus WL<51>: voltage dc dc=0 srcType=dc
  Stimulus WL<50>: voltage dc dc=0 srcType=dc
  Stimulus WL<49>: voltage dc dc=0 srcType=dc
  Stimulus WL<48>: voltage dc dc=0 srcType=dc
  Stimulus WL<47>: voltage dc dc=0 srcType=dc
  Stimulus WL<46>: voltage dc dc=0 srcType=dc
  Stimulus WL<45>: voltage dc dc=0 srcType=dc
  Stimulus WL<44>: voltage dc dc=0 srcType=dc
  Stimulus WL<43>: voltage dc dc=0 srcType=dc
  Stimulus WL<42>: voltage dc dc=0 srcType=dc
  Stimulus WL<41>: voltage dc dc=0 srcType=dc
  Stimulus WL<40>: voltage dc dc=0 srcType=dc
  Stimulus WL<39>: voltage dc dc=0 srcType=dc
  Stimulus WL<38>: voltage dc dc=0 srcType=dc
  Stimulus WL<37>: voltage dc dc=0 srcType=dc
  Stimulus WL<36>: voltage dc dc=0 srcType=dc
  Stimulus WL<35>: voltage dc dc=0 srcType=dc
  Stimulus WL<34>: voltage dc dc=0 srcType=dc
  Stimulus WL<33>: voltage dc dc=0 srcType=dc
  Stimulus WL<32>: voltage dc dc=0 srcType=dc
  Stimulus WL<31>: voltage pulse val0=0 val1=1 period=1n delay=1n rise=5p fall=5p width=10p srcType=pulse
  Stimulus WL<30>: voltage dc dc=0 srcType=dc
  Stimulus WL<29>: voltage dc dc=0 srcType=dc
  Stimulus WL<28>: voltage dc dc=0 srcType=dc
  Stimulus WL<27>: voltage dc dc=0 srcType=dc
  Stimulus WL<26>: voltage dc dc=0 srcType=dc
  Stimulus WL<25>: voltage dc dc=0 srcType=dc
  Stimulus WL<24>: voltage dc dc=0 srcType=dc
  Stimulus WL<23>: voltage dc dc=0 srcType=dc
  Stimulus WL<22>: voltage dc dc=0 srcType=dc
  Stimulus WL<21>: voltage dc dc=0 srcType=dc
  Stimulus WL<20>: voltage dc dc=0 srcType=dc
  Stimulus WL<19>: voltage dc dc=0 srcType=dc
  Stimulus WL<18>: voltage dc dc=0 srcType=dc
  Stimulus WL<17>: voltage dc dc=0 srcType=dc
  Stimulus WL<16>: voltage dc dc=0 srcType=dc
  Stimulus WL<15>: voltage dc dc=0 srcType=dc
  Stimulus WL<14>: voltage dc dc=0 srcType=dc
  Stimulus WL<13>: voltage dc dc=0 srcType=dc
  Stimulus WL<12>: voltage dc dc=0 srcType=dc
  Stimulus WL<11>: voltage dc dc=0 srcType=dc
  Stimulus WL<10>: voltage dc dc=0 srcType=dc
  Stimulus WL<9>: voltage dc dc=0 srcType=dc
  Stimulus WL<8>: voltage dc dc=0 srcType=dc
  Stimulus WL<7>: voltage dc dc=0 srcType=dc
  Stimulus WL<6>: voltage dc dc=0 srcType=dc
  Stimulus WL<5>: voltage dc dc=0 srcType=dc
  Stimulus WL<4>: voltage dc dc=0 srcType=dc
  Stimulus WL<3>: voltage dc dc=0 srcType=dc
  Stimulus WL<2>: voltage dc dc=0 srcType=dc
  Stimulus WL<1>: voltage dc dc=0 srcType=dc
  Stimulus WL<0>: voltage dc dc=0 srcType=dc
  Stimulus BL: voltage pulse dc=1 val0=0 val1=1 period=2n delay=500.0p rise=20p fall=20p width=1n srcType=pulse
  Stimulus BLB: voltage pulse val0=1 val1=0 period=2n delay=500.0p rise=20p fall=20p width=1n srcType=pulse
  Initial conditions: /i6t_sram<31>/Qb = 1; /i6t_sram<31>/Q = 0
  Analysis tran: stop=5n
  Signals: /BL, /BLB, /WL<31>, /i6t_sram<31>/Q, /i6t_sram<31>/Qb
Run mode: Single Run, Sweeps and Corners
