ADE simulation setup
Run mode: Single Run, Sweeps and Corners
Tests:
  AVD_Project_6t_sram_tb_1: AVD_Project/6t_sram_column_tb/schematic, simulator spectre
    Outputs: /WL<31>
