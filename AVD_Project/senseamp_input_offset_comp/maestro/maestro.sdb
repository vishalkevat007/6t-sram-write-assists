ADE simulation setup
Run mode: Single Run, Sweeps and Corners
Tests:
  AVD_Project_write_assist_tb_1: AVD_Project/senseamp_input_offset_comp/schematic, simulator spectre
