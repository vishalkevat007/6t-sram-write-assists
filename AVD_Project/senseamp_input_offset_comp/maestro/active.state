ADE simulation setup
Test AVD_Project_write_assist_tb_1: AVD_Project/senseamp_input_offset_comp/schematic, simulator spectre
  Models: /package/eda/cadence/gpdk045/gpdk045_v_6_0/gpdk045/../models/spectre/gpdk045.scs[tt]
  Temperature: 27
  Stimulus glat_clkb: voltage pulse val0=1 val1=0 period=1n delay=230.00p rise=5p fall=5p width=25p srcType=pulse
  Stimulus en: voltage pulse val0=0 val1=1 period=1n delay=135.00p rise=5p fall=5p width=30p srcType=pulse
  Stimulus pchgb: voltage pulse dc=1 val0=0 val1=1 period=1n delay=20p rise=5p fall=5p width=250p srcType=pulse
  Stimulus cselb: voltage pulse dc=1 val0=1 val1=0 period=1n delay=105p rise=5p fall=5p width=20p srcType=pulse
  Stimulus Gnd: voltage dc dc=0 srcType=dc
  Stimulus WL<7>: voltage dc dc=0 srcType=dc
  Stimulus WL<6>: voltage dc dc=0 srcType=dc
  Stimulus WL<5>: voltage dc dc=0 srcType=dc
  Stimulus WL<4>: voltage dc dc=0 srcType=dc
  Stimulus WL<3>: voltage dc dc=0 srcType=dc
  Stimulus WL<2>: voltage dc dc=0 srcType=dc
  Stimulus WL<1>: voltage dc dc=0 srcType=dc
  Stimulus WL<0>: voltage pulse val0=0 val1=1 period=1n delay=100.00p rise=5p fall=5p width=25p srcType=pulse
  Stimulus Pch: voltage pulse dc=1 val0=0 val1=1 period=1n delay=20p rise=5p fall=5p width=250p srcType=pulse
  Stimulus Vdd: voltage dc dc=1 srcType=dc
  Initial conditions: /glat_out = 0; /isram_6t<0>/Qb = 1; /isram_6t<0>/Q = 0
  Analysis tran: stop=0.5n step=1e-9 method=euler
  Signals: /WL<0>, /BL, /BLB, /cselb, /pchgb, /en, /lat, /latb, /nsrc, /ct0, /ct1, /glat_clkb, /Dout
Run mode: Single Run, Sweeps and Corners
