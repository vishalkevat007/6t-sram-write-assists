ADE simulation setup
Test AVD_Project_6t_sram_tb_1: AVD_Project/6t_sram_tb/schematic, simulator spectre
  Models: /package/eda/cadence/gpdk045/gpdk045_v_6_0/gpdk045/../models/spectre/gpdk045.scs[tt]
  Temperature: 27
  Stimulus Vdd: voltage dc dc=1 srcType=dc
  Stimulus Vss: voltage dc dc=0 srcType=dc
  Stimulus WL: voltage pulse dc=1 val0=0 val1=1 period=1n delay=1n rise=5p fall=5p width=5p srcType=pulse
  Stimulus BL: voltage pulse dc=1 val0=0 val1=1 period=2n delay=500.0p rise=20p fall=20p width=1n srcType=pulse
  Stimulus BLB: voltage pulse dc=1 val0=1 val1=0 period=2n delay=500.0p rise=20p fall=20p width=1n srcType=pulse
  Initial conditions: /i6t_sram/Qb = 1; /i6t_sram/Q = 0
  Analysis tran: stop=5n
  Signals: /WL, /Vdd, /BL, /BLB, /Vss, /i6t_sram/Q, /i6t_sram/Qb
Run mode: Single Run, Sweeps and Corners
