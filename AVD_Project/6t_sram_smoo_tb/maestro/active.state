ADE simulation setup
Test AVD_Project_6t_sram_smoo_tb_1: AVD_Project/6t_sram_smoo_tb/schematic, simulator spectre
  Models: /package/eda/cadence/gpdk045/gpdk045_v_6_0/gpdk045/../models/spectre/gpdk045.scs[sf]
  Variables: Vdd_main = 1; PW = 8p; BLB_Vdd = 0; Vdd_col = 0.5; BL_Vdd = Vdd_main; WL_Vdd = Vdd_main
  Temperature: 27
  Stimulus vdd!: voltage dc dc=Vdd_col srcType=dc
  Stimulus WL: voltage pulse dc=0 val0=0 val1=WL_Vdd period=1n delay=250p rise=5p fall=5p width=PW srcType=pulse
  Stimulus BL: voltage dc dc=BL_Vdd srcType=dc
  Stimulus BLB: voltage dc dc=BLB_Vdd srcType=dc
  Initial conditions: /i6t_sram/Qb = Vdd_col; /i6t_sram/Q = 0
  Analysis tran: stop=1n
  Output Vdd_main = VAR("Vdd_main")
  Output Vdd_col = VAR("Vdd_col")
  Output BLB_Vdd = VAR("BLB_Vdd")
  Output PW = VAR("PW")
  Output WL_Fall = cross(VT("/WL") (VAR("WL_Vdd") * 0.5) 1 "falling") (unticked)
  Output TimeCross = cross((VT("/i6t_sram/Q") - VT("/i6t_sram/Qb")) 0 1 "either") (unticked)
  Output VQ_Final = value(VT("/i6t_sram/Q") (WL_Fall + 1e-10)) (unticked)
  Output Pass = if(((TimeCross != nil) && (TimeCross < WL_Fall) && (VQ_Final > (0.9 * VAR("Vdd_col")))) then 1 else 0)
  Output Pass2 = if((value(VT("/i6t_sram/Q") 9e-10) >= (0.9 * VAR("Vdd_col"))) then 1 else 0) (unticked)
  Signals: /WL, /BL, /BLB, /i6t_sram/Q, /i6t_sram/Qb
Run mode: Single Run, Sweeps and Corners
