ADE simulation setup
Run mode: Single Run, Sweeps and Corners
Tests:
  AVD_Project_6t_sram_smoo_tb_1: AVD_Project/6t_sram_smoo_tb/schematic, simulator spectre
    Variables: PW = 8p; Vdd_col = 0.5; BL_Vdd = Vdd_main; BLB_Vdd = 0; WL_Vdd = Vdd_main; Vdd_main = 1
    Outputs: ((finalValue (V "/Q")) > (VDD / 2)); ((finalValue (V "/Q")) > (Vdd / 2)); ((finalValue (V "/i6t_sram/Q")) > (Vdd / 2)); nil; ((value(VT("/i6t_sram/Q") 6e-10) > 0.9) ? (1:0)); if((value(VT("/i6t_sram/Q") 6e-10) > 0.9) then 1 else 0); if((value(VT("/i6t_sram/Q") 6e-10) > VAR("VDd")) then 1 else 0); if((value(VT("/i6t_sram/Q") 6e-10) > VAR("Vdd")) then 1 else 0); if((value(VT("/i6t_sram/Q") 6e-10) > (0.9 * VAR("Vdd"))) then 1 else 0); if((value(VT("/i6t_sram/Q") 6e-10) >= (0.9 * VAR("Vdd"))) then 1 else 0); Pass2; Vdd_col; PW; BLB_Vdd; WL_Fall; cross((VT("/Q") - VT("/QB")) 0 1 "either"); TimeCross; value(VT("/Q") (cross(VT("/WL") (VAR("Vdd") * 0.5) 1 "falling") + 1e-10)); VQ_Final; Pass; Vdd_main
