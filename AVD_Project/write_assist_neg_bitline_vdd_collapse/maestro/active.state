ADE simulation setup
Test AVD_Project_write_assist_tb_1: AVD_Project/write_assist_neg_bitline_vdd_collapse/schematic, simulator spectre
  Models: /package/eda/cadence/gpdk045/gpdk045_v_6_0/gpdk045/../models/spectre/gpdk045.scs[sf]
  Temperature: 27
  Stimulus cutVDDb: voltage pulse val0=0 val1=1 period=2n delay=1.19n rise=5p fall=5p width=120p srcType=pulse
  Stimulus pullVDD: voltage pulse val0=1 val1=0 period=2n delay=1.19n rise=5p fall=5p width=120p srcType=pulse
  Stimulus pullCap: voltage pulse val0=0 val1=1 period=2n delay=1.24n rise=5p fall=5p width=25p srcType=pulse
  Stimulus DGATE: voltage pulse val0=0 val1=1 period=2n delay=1.19n rise=5p fall=5p width=30p srcType=pulse
  Stimulus DBGATE: voltage pulse val0=0 val1=1 period=2n delay=200p rise=5p fall=5p width=104p srcType=pulse
  Stimulus DSEL: voltage pulse val0=0 val1=1 period=2n delay=1.19n rise=5p fall=5p width=100p srcType=pulse
  Stimulus DBSEL: voltage pulse val0=0 val1=0 period=1n delay=1.27n rise=5p fall=5p width=25p srcType=pulse
  Stimulus WL<7>: voltage dc dc=0 srcType=dc
  Stimulus WL<6>: voltage dc dc=0 srcType=dc
  Stimulus WL<5>: voltage dc dc=0 srcType=dc
  Stimulus WL<4>: voltage dc dc=0 srcType=dc
  Stimulus WL<3>: voltage dc dc=0 srcType=dc
  Stimulus WL<2>: voltage dc dc=0 srcType=dc
  Stimulus WL<1>: voltage dc dc=0 srcType=dc
  Stimulus WL<0>: voltage pulse val0=0 val1=1 period=1n delay=300.00p rise=5p fall=5p width=130p srcType=pulse
  Stimulus Pch: voltage pulse dc=1 val0=0 val1=1 period=1n delay=150p rise=5p fall=5p width=300p srcType=pulse
  Stimulus Vdd: voltage dc dc=1 srcType=dc
  Stimulus Gnd: voltage dc dc=0 srcType=dc
  Initial conditions: /NCR = 0; /NCL = 0; /Vdd_col = 1; /isram_6t<0>/Qb = 0; /isram_6t<0>/Q = 1
  Analysis tran: stop=3n step=1e-9 method=euler
  Signals: /Vdd, /Vdd_col, /Pch, /cutVDDb, /pullVDD, /pullCap, /NCL, /NCR, /WL<0>, /DBGATE, /DGATE, /DBSEL, /DSEL, /BL, /BLB, /isram_6t<0>/Q, /isram_6t<0>/Qb
Run mode: Single Run, Sweeps and Corners
