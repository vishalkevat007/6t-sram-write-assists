ADE simulation setup
Run mode: Single Run, Sweeps and Corners
Tests:
  AVD_Project_write_assist_tb_1: AVD_Project/write_assist_neg_bitline_vdd_collapse/schematic, simulator spectre
